* C:\FOSSEE\eSim\library\SubcircuitLibrary\MSK032\MSK032.cir

* EESchema Netlist Version 1.1 (Spice format) creation date: 06/26/25 23:36:42

* To exclude a component from the Spice Netlist add [Spice_Netlist_Enabled] user FIELD set to: N
* To reorder the component spice node sequence add [Spice_Node_Sequence] user FIELD and define sequence: 2,1,0

* Sheet Name: /
J1  Net-_I2-Pad1_ Net-_J1-Pad2_ Net-_J1-Pad3_ eSim_NJF
J2  Net-_I2-Pad1_ Net-_J2-Pad2_ Net-_J2-Pad3_ eSim_NJF
R1  Net-_J1-Pad3_ Net-_I1-Pad1_ 1.6k
R2  Net-_I1-Pad1_ Net-_J2-Pad3_ 1.6k
I1  Net-_I1-Pad1_ Net-_I1-Pad2_ dc
Q1  Net-_D1-Pad1_ Net-_I2-Pad1_ Net-_I2-Pad2_ eSim_PNP
Q5  Net-_Q3-Pad1_ Net-_I2-Pad1_ Net-_I2-Pad2_ eSim_PNP
I2  Net-_I2-Pad1_ Net-_I2-Pad2_ dc
D1  Net-_D1-Pad1_ Net-_D1-Pad2_ eSim_Diode
Q2  Net-_D1-Pad2_ Net-_D1-Pad2_ Net-_I1-Pad2_ eSim_NPN
Q3  Net-_Q3-Pad1_ Net-_D1-Pad1_ Net-_Q3-Pad3_ eSim_NPN
Q4  Net-_Q3-Pad3_ Net-_D1-Pad2_ Net-_I1-Pad2_ eSim_NPN
Q6  Net-_I2-Pad1_ Net-_Q3-Pad1_ Net-_Q6-Pad3_ eSim_NPN
R3  Net-_Q6-Pad3_ Net-_R3-Pad2_ 33
R4  Net-_R3-Pad2_ Net-_Q7-Pad3_ 33
Q7  Net-_I1-Pad2_ Net-_Q3-Pad1_ Net-_Q7-Pad3_ eSim_PNP
U1  ? Net-_Q3-Pad1_ Net-_I2-Pad1_ Net-_I2-Pad1_ Net-_J2-Pad2_ Net-_J1-Pad2_ ? GND ? Net-_I1-Pad2_ Net-_R3-Pad2_ Net-_I2-Pad1_ PORT

.end
